* Write SNM - 6T cell with WL=1, opposite data driven on BL/BR
.option scale=1e-6
.temp 25
.include ../pex/cell6t_pex.sp
.lib "SKY130_MODEL_PATH" tt

VDD vdd 0 1.8
VWL wl 0 1.8
VBL bl 0 0
VBR br 0 1.8

.tran 0.01n 5n
.control
run
write write_snm.raw
.endc
.end
